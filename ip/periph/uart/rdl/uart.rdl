// SystemRDL register map for the UART. Generate the AXI-Lite regblock with:
//   peakrdl regblock uart.rdl -o ../rtl/ --cpuif axi4-lite
addrmap uart {
    reg { field { sw=rw; hw=r; } data[8]; } TX @ 0x0;
    reg { field { sw=r;  hw=w; } data[8]; } RX @ 0x4;
    reg {
        field { sw=r; hw=w; } tx_ready[0:0];
        field { sw=r; hw=w; } rx_valid[1:1];
    } STATUS @ 0x8;
};
